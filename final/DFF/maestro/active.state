ADE simulation setup
Test final_DFF_1: final/DFF/schematic, simulator spectre
  Models: /home/viterbi/01/ee577/CDS_GPDK45/gpdk045_v_5_0/gpdk045/../models/spectre/gpdk045.scs[mc]
  Temperature: 27
  Stimulus vdd!: voltage dc dc=1
  Stimulus D: voltage bit rise=10p fall=10p period=1n data=0000110000
  Stimulus clk: voltage bit rise=10p fall=10p period=1n data=0101010101
  Analysis tran: stop=10n
  Signals: /clk, /D, /Q

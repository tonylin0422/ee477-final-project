ADE simulation setup
Run mode: Single Run, Sweeps and Corners
Tests:
  final_tgate_1: final/tgate/schematic, simulator spectre

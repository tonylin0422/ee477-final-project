ADE simulation setup
Test demo_lab1_1_bit_full_adder_1: demo_lab1/1_bit_full_adder/schematic, simulator spectre
  Models: /home/viterbi/01/ee577/CDS_GPDK45/gpdk045_v_5_0/gpdk045/../models/spectre/gpdk045.scs[mc]
  Temperature: 27
  Stimulus A: voltage bit val1=1 val0=0 rise=10p fall=10p period=1n data=00
  Stimulus B: voltage bit val1=1 val0=0 rise=10p fall=10p period=1n data=11
  Stimulus Cin: voltage bit val1=1 val0=0 rise=10p fall=10p period=1n data=10
  Analysis tran: stop=10n errpreset=conservative
  Signals: /Cin, /S, /Cout

ADE simulation setup
Test final_tgate_1: final/tgate/schematic, simulator spectre
  Models: /home/viterbi/01/ee577/CDS_GPDK45/gpdk045_v_5_0/gpdk045/../models/spectre/gpdk045.scs[mc]
  Temperature: 27
  Stimulus D: voltage dc dc=1
  Stimulus clk: voltage bit rise=10p fall=10p period=1n data=10101010
  Stimulus clkb: voltage bit rise=10p fall=10p period=1n data=01010101
  Analysis tran: stop=10n
  Signals: /Q, /D, /clk, /clkb

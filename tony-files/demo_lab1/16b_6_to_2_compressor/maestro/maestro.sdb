ADE simulation setup
Run mode: Single Run, Sweeps and Corners
Tests:
  demo_lab1_16b_6_to_2_compressor_1: demo_lab1/16b_6_to_2_compressor/schematic, simulator spectre

ADE simulation setup
Run mode: Single Run, Sweeps and Corners
Tests:
  final_DFF_1: final/DFF/schematic, simulator spectre

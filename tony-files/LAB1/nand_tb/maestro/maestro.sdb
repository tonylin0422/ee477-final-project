ADE simulation setup
Run mode: Single Run, Sweeps and Corners
Tests:
  LAB1_nand_tb_1: LAB1/nand_tb/config, simulator spectre

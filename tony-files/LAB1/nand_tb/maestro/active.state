ADE simulation setup
Test LAB1_nand_tb_1: LAB1/nand_tb/config, simulator spectre
  Models: /home/viterbi/01/ee577/CDS_GPDK45/gpdk045_v_5_0/gpdk045/../models/spectre/gpdk045.scs[mc]
  Temperature: 27
  Stimulus vdd!: voltage dc dc=1
  Stimulus in1: voltage bit val1=0 val0=1 rise=10p fall=10p period=1n data=00110 rpttimes=10
  Stimulus in2: voltage bit val1=0 val0=1 rise=10p fall=10p period=1n data=0110 rpttimes=10
  Analysis tran: stop=50n
  Signals: /in_1, /in_2, /out
Run mode: Single Run, Sweeps and Corners

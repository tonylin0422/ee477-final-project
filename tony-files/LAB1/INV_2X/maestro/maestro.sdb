ADE simulation setup
Run mode: Single Run, Sweeps and Corners
Tests:
  LAB1_INV_2X_1: LAB1/INV_2X/schematic, simulator spectre

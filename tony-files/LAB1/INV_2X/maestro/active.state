ADE simulation setup
Test LAB1_INV_2X_1: LAB1/INV_2X/schematic, simulator spectre
  Models: /home/viterbi/01/ee577/CDS_GPDK45/gpdk045_v_5_0/gpdk045/../models/spectre/gpdk045.scs[mc]
  Temperature: 27
Run mode: Single Run, Sweeps and Corners

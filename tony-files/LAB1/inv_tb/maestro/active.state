ADE simulation setup
Test LAB1_inv_tb_1: LAB1/inv_tb/config, simulator spectre
  Models: /home/viterbi/01/ee577/CDS_GPDK45/gpdk045_v_5_0/gpdk045/../models/spectre/gpdk045.scs[mc]
  Temperature: 27
  Stimulus vdd!: voltage dc dc=1
  Stimulus in: voltage bit val1=1 val0=0 rise=10p fall=10p period=1n data=1010101010
  Analysis tran: stop=10n
  Signals: /in1, /out1
Run mode: Single Run, Sweeps and Corners

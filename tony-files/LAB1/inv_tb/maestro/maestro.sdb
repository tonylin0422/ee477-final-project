ADE simulation setup
Run mode: Single Run, Sweeps and Corners
Tests:
  LAB1_inv_tb_1: LAB1/inv_tb/config, simulator spectre

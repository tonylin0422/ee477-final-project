ADE simulation setup
Test LAB1_INV_1X_1: LAB1/INV_1X/av_extracted, simulator spectre
  Models: /home/viterbi/01/ee577/CDS_GPDK45/gpdk045_v_5_0/gpdk045/../models/spectre/gpdk045.scs[mc]
  Temperature: 27
  Stimulus in: voltage bit val1=1 val0=0 rise=10p fall=10p period=1n data=10101010
  Stimulus gnd!: voltage dc dc=0
  Stimulus vdd!: voltage dc dc=1
  Analysis tran: stop=10n
  Signals: /3:in, /out
Run mode: Single Run, Sweeps and Corners

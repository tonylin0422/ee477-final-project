ADE simulation setup
Run mode: Single Run, Sweeps and Corners
Tests:
  LAB1_INV_1X_1: LAB1/INV_1X/av_extracted, simulator spectre

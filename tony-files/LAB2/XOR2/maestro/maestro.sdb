ADE simulation setup
Run mode: Single Run, Sweeps and Corners
Tests:
  LAB2_XOR2_1: LAB2/XOR2/schematic, simulator spectre

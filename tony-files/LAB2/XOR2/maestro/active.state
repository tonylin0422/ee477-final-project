ADE simulation setup
Test LAB2_XOR2_1: LAB2/XOR2/schematic, simulator spectre
  Models: /home/viterbi/01/ee577/CDS_GPDK45/gpdk045_v_5_0/gpdk045/../models/spectre/gpdk045.scs[mc]
  Temperature: 27
  Stimulus vdd!: voltage dc dc=1
  Stimulus A: voltage bit val1=1 val0=0 rise=10p fall=10p period=1n data=00011011 rpttimes=3
  Stimulus B: voltage bit val1=1 val0=0 rise=10p fall=10p period=1n data=01001110 rpttimes=3
  Analysis tran: stop=10n
  Signals: /A, /B, /out
Run mode: Single Run, Sweeps and Corners

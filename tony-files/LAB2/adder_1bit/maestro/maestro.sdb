ADE simulation setup
Run mode: Single Run, Sweeps and Corners
Tests:
  LAB2_adder_1bit_1: LAB2/adder_1bit/schematic, simulator spectre

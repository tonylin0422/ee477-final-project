ADE simulation setup
Test LAB2_adder_1bit_1: LAB2/adder_1bit/schematic, simulator spectre
  Models: /home/viterbi/01/ee577/CDS_GPDK45/gpdk045_v_5_0/gpdk045/../models/spectre/gpdk045.scs[mc]
  Temperature: 27
  Stimulus A: voltage dc dc=0
  Stimulus B: voltage dc dc=1
  Stimulus Cin: voltage bit rise=10p fall=10p period=1n data=0110
  Analysis tran: stop=10n
  Signals: /A, /B, /Cin, /S, /Cout, /net1
Run mode: Single Run, Sweeps and Corners

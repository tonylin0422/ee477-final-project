ADE simulation setup
Run mode: Single Run, Sweeps and Corners
Tests:
  LAB2_adder_dut_1: LAB2/adder_dut/config, simulator spectre

ADE simulation setup
Run mode: Single Run, Sweeps and Corners
Tests:
  LAB2_adder_4bit_dut_1: LAB2/adder_4bit_dut/schematic, simulator spectre

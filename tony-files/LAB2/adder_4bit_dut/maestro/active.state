ADE simulation setup
Test LAB2_adder_4bit_dut_1: LAB2/adder_4bit_dut/schematic, simulator spectre
  Models: /home/viterbi/01/ee577/CDS_GPDK45/gpdk045_v_5_0/gpdk045/../models/spectre/gpdk045.scs[mc]
  Temperature: 27
  Stimulus vdd!: voltage dc dc=1
  Stimulus Cin: voltage bit rise=10p fall=10p period=1n data=010101
  Stimulus A0: voltage bit rise=10p fall=10p period=1n data=010011
  Stimulus A1: voltage bit rise=10p fall=10p period=1n data=011011
  Stimulus A2: voltage bit rise=10p fall=10p period=1n data=011111
  Stimulus A3: voltage bit rise=10p fall=10p period=1n data=011111
  Stimulus B0: voltage bit rise=10p fall=10p period=1n data=011100
  Stimulus B1: voltage bit rise=10p fall=10p period=1n data=010100
  Stimulus B2: voltage bit rise=10p fall=10p period=1n data=010000
  Stimulus B3: voltage bit rise=10p fall=10p period=1n data=010000
  Analysis tran: stop=10n
  Signals: /S3, /Cout, /Cin, /A0, /A1, /A2, /A3, /B0, /B1, /B2, /B3
Run mode: Single Run, Sweeps and Corners

ADE simulation setup
Run mode: Single Run, Sweeps and Corners
Tests:
  LAB3_MUX_4X_1: LAB3/MUX_4X/schematic, simulator spectre

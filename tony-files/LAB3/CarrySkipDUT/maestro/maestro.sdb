ADE simulation setup
Run mode: Single Run, Sweeps and Corners
Tests:
  LAB3_CarrySkipDUT_1: LAB3/CarrySkipDUT/config, simulator spectre

ADE simulation setup
Test LAB3_CarrySkipDUT_1: LAB3/CarrySkipDUT/config, simulator spectre
  Models: /home/viterbi/01/ee577/CDS_GPDK45/gpdk045_v_5_0/gpdk045/../models/spectre/gpdk045.scs[mc]
  Temperature: 27
  Files: vectors /home/viterbi/09/tlin9034/work_gpdk045/LAB3/test.vec
  Analysis tran: stop=10n
  Signals: /A0, /A1, /A2, /A3, /A4, /I8/in (terminal), /I8/out (terminal), /A5, /A6, /A7, /B0, /I11/in (terminal), /I11/out (terminal), /B1, /I13/in (terminal), /I13/out (terminal), /B3, /B4, /B5, /B6, /B7, /B2, /Cin, /S0, /S1, /S2, /S3, /S4, /S5, /S6, /S7, /Cout
Run mode: Single Run, Sweeps and Corners

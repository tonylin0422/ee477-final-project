ADE simulation setup
Run mode: Single Run, Sweeps and Corners
Tests:
  LAB3_CarrySkip8_1: LAB3/CarrySkip8/schematic, simulator spectre

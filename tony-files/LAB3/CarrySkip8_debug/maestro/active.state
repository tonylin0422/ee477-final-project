ADE simulation setup
Test LAB3_CarrySkip8_1: LAB3/CarrySkip8/schematic, simulator spectre
  Models: /home/viterbi/01/ee577/CDS_GPDK45/gpdk045_v_5_0/gpdk045/../models/spectre/gpdk045.scs[mc]
  Temperature: 27
  Files: vectors /home/viterbi/09/tlin9034/work_gpdk045/LAB3/test.vec
  Analysis tran: stop=10n
  Signals: /Cout, /A0, /A1, /A2, /A3, /A4, /A5, /A6, /A7, /B0, /B1, /B2, /B3, /B4, /B5, /B6, /B7, /S0, /S1, /S2, /S3, /S4, /S5, /S6, /S7, /Cin
Run mode: Single Run, Sweeps and Corners

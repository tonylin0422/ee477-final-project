ADE simulation setup
Run mode: Single Run, Sweeps and Corners
Tests:
  LAB3_MUX_1X_1: LAB3/MUX_1X/layout, simulator spectre

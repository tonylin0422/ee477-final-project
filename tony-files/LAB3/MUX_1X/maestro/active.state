ADE simulation setup
Test LAB3_MUX_1X_1: LAB3/MUX_1X/layout, simulator spectre
  Models: /home/viterbi/01/ee577/CDS_GPDK45/gpdk045_v_5_0/gpdk045/../models/spectre/gpdk045.scs[mc]
  Temperature: 27
  Stimulus A: voltage bit rise=10p fall=10p period=1n data=00001111
  Stimulus B: voltage bit rise=10p fall=10p period=1n data=00111100
  Stimulus S: voltage bit rise=10p fall=10p period=1n data=01100110
  Analysis tran: stop=10n
  Signals: /A, /B, /S, /out
Run mode: Single Run, Sweeps and Corners

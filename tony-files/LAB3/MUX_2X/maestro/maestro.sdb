ADE simulation setup
Run mode: Single Run, Sweeps and Corners
Tests:
  LAB3_MUX_2X_1: LAB3/MUX_2X/schematic, simulator spectre

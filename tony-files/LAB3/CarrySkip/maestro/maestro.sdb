ADE simulation setup
Run mode: Single Run, Sweeps and Corners
Tests:
  LAB3_CarrySkip_1: LAB3/CarrySkip/schematic, simulator spectre

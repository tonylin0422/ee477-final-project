ADE simulation setup
Test LAB3_CarrySkip_1: LAB3/CarrySkip/schematic, simulator spectre
  Models: /home/viterbi/01/ee577/CDS_GPDK45/gpdk045_v_5_0/gpdk045/../models/spectre/gpdk045.scs[mc]
  Temperature: 27
  Files: vectors /home/viterbi/09/tlin9034/work_gpdk045/LAB3/4bittest.vec
  Stimulus vdd!: voltage dc dc=1
  Analysis tran: stop=10n
  Signals: /A0, /A1, /B0, /B1, /P0, /P1
Run mode: Single Run, Sweeps and Corners

ADE simulation setup
Run mode: Single Run, Sweeps and Corners
Tests:
  demo_lab1_1_bit_full_adder_1: demo_lab1/1_bit_full_adder/schematic, simulator spectre

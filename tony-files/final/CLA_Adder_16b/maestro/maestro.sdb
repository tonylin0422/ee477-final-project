ADE simulation setup
Run mode: Single Run, Sweeps and Corners
Tests:
  demo_lab1_CLA_Adder_16b_1: demo_lab1/CLA_Adder_16b/schematic, simulator spectre

ADE simulation setup
Test demo_lab1_CLA_Adder_16b_1: demo_lab1/CLA_Adder_16b/schematic, simulator spectre
  Models: /home/viterbi/01/ee577/CDS_GPDK45/gpdk045_v_5_0/gpdk045/../models/spectre/gpdk045.scs[mc]
  Temperature: 27
  Stimulus A0: voltage bit val1=1 val0=0 rise=10p fall=10p period=1n data=110
  Stimulus A1: voltage bit val1=1 val0=0 rise=10p fall=10p period=1n data=010
  Stimulus A2: voltage bit val1=1 val0=0 rise=10p fall=10p period=1n data=110
  Stimulus A3: voltage bit val1=1 val0=0 rise=10p fall=10p period=1n data=010
  Stimulus A4: voltage bit val1=1 val0=0 rise=10p fall=10p period=1n data=110
  Stimulus A5: voltage bit val1=1 val0=0 rise=10p fall=10p period=1n data=010
  Stimulus A6: voltage bit val1=1 val0=0 rise=10p fall=10p period=1n data=110
  Stimulus A7: voltage bit val1=1 val0=0 rise=10p fall=10p period=1n data=010
  Stimulus A8: voltage bit val1=1 val0=0 rise=10p fall=10p period=1n data=110
  Stimulus A9: voltage bit val1=1 val0=0 rise=10p fall=10p period=1n data=010
  Stimulus A10: voltage bit val1=1 val0=0 rise=10p fall=10p period=1n data=110
  Stimulus A11: voltage bit val1=1 val0=0 rise=10p fall=10p period=1n data=010
  Stimulus A12: voltage bit val1=1 val0=0 rise=10p fall=10p period=1n data=110
  Stimulus A13: voltage bit val1=1 val0=0 rise=10p fall=10p period=1n data=010
  Stimulus A14: voltage bit val1=1 val0=0 rise=10p fall=10p period=1n data=110
  Stimulus A15: voltage bit val1=1 val0=0 rise=10p fall=10p period=1n data=010
  Stimulus B0: voltage bit val1=1 val0=0 rise=10p fall=10p period=1n data=000
  Stimulus B1: voltage bit val1=1 val0=0 rise=10p fall=10p period=1n data=110
  Stimulus B2: voltage bit val1=1 val0=0 rise=10p fall=10p period=1n data=000
  Stimulus B3: voltage bit val1=1 val0=0 rise=10p fall=10p period=1n data=110
  Stimulus B4: voltage bit val1=1 val0=0 rise=10p fall=10p period=1n data=100
  Stimulus B5: voltage bit val1=1 val0=0 rise=10p fall=10p period=1n data=011
  Stimulus B6: voltage bit val1=1 val0=0 rise=10p fall=10p period=1n data=100
  Stimulus B7: voltage bit val1=1 val0=0 rise=10p fall=10p period=1n data=110
  Stimulus B8: voltage bit val1=1 val0=0 rise=10p fall=10p period=1n data=000
  Stimulus B9: voltage bit val1=1 val0=0 rise=10p fall=10p period=1n data=010
  Stimulus B10: voltage bit val1=1 val0=0 rise=10p fall=10p period=1n data=000
  Stimulus B11: voltage bit val1=1 val0=0 rise=10p fall=10p period=1n data=010
  Stimulus B12: voltage bit val1=1 val0=0 rise=10p fall=10p period=1n data=000
  Stimulus B13: voltage bit val1=1 val0=0 rise=10p fall=10p period=1n data=010
  Stimulus B14: voltage bit val1=1 val0=0 rise=10p fall=10p period=1n data=000
  Stimulus B15: voltage bit val1=1 val0=0 rise=10p fall=10p period=1n data=010
  Stimulus Cin: voltage bit val1=1 val0=0 rise=10p fall=10p period=1n data=000
  Stimulus vdd!: voltage dc dc=1
  Analysis tran: stop=10n errpreset=conservative
  Signals: /A0, /A1, /A2, /A3, /A4, /A5, /A6, /A7, /A8, /A9, /A10, /A11, /A12, /A13, /A14, /A15, /B0, /B1, /B2, /B3, /B4, /B5, /B6, /B7, /B8, /B9, /B10, /B11, /B12, /B13, /B14, /B15, /Cin, /S0, /S1, /S2, /S3, /S4, /S5, /S6, /S7, /S8, /S9, /S10, /S11, /S12, /S13, /S14, /S15, /Cout
Run mode: Single Run, Sweeps and Corners

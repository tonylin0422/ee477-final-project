ADE simulation setup
Test final_booth_encoder_1: final/booth_encoder/schematic, simulator spectre
  Models: /home/viterbi/01/ee577/CDS_GPDK45/gpdk045_v_5_0/gpdk045/../models/spectre/gpdk045.scs[mc]
  Temperature: 27
  Stimulus vdd!: voltage dc dc=1
  Stimulus X_2i-1: voltage bit rise=10p fall=10p period=1n data=01010101
  Stimulus X_2i: voltage bit rise=10p fall=10p period=1n data=00110011
  Stimulus X_2i+1: voltage bit rise=10p fall=10p period=1n data=00001111
  Stimulus zero: voltage bit rise=10p fall=10p period=1n data=00000000
  Stimulus in7: voltage bit rise=10p fall=10p period=1n data=00000111
  Stimulus in6: voltage bit rise=10p fall=10p period=1n data=00011000
  Stimulus in5: voltage bit rise=10p fall=10p period=1n data=11111000
  Stimulus in4: voltage bit rise=10p fall=10p period=1n data=11111111
  Stimulus in3: voltage bit rise=10p fall=10p period=1n data=11100000
  Stimulus in0: voltage bit rise=10p fall=10p period=1n data=00000111
  Stimulus in-1: voltage bit rise=10p fall=10p period=1n data=00000000
  Stimulus in1: voltage bit rise=10p fall=10p period=1n data=11100111
  Stimulus in2: voltage bit rise=10p fall=10p period=1n data=00000111
  Analysis tran: stop=10n
  Signals: /in7, /in6, /in5, /in4, /in3, /in2, /in1, /in0, /X_2i+1, /X_2i, /X_2i-1, /out8, /out7, /out6, /out5, /out4, /out3, /out2, /out1, /out0
Run mode: Single Run, Sweeps and Corners

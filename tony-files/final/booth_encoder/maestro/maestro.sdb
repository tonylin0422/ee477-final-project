ADE simulation setup
Run mode: Single Run, Sweeps and Corners
Tests:
  final_booth_encoder_1: final/booth_encoder/schematic, simulator spectre

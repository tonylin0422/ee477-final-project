ADE simulation setup
Test demo_lab1_4_bit_rca_1: demo_lab1/4_bit_rca/schematic, simulator spectre
  Models: /home/viterbi/01/ee577/CDS_GPDK45/gpdk045_v_5_0/gpdk045/../models/spectre/gpdk045.scs[mc]
  Temperature: 27
  Stimulus A0: voltage bit val1=1 val0=0 rise=10p fall=10p period=1n data=100
  Stimulus A1: voltage bit val1=1 val0=0 rise=10p fall=10p period=1n data=110
  Stimulus A2: voltage bit val1=1 val0=0 rise=10p fall=10p period=1n data=111
  Stimulus A3: voltage bit val1=1 val0=0 rise=10p fall=10p period=1n data=111
  Stimulus B0: voltage bit val1=1 val0=0 rise=10p fall=10p period=1n data=111
  Stimulus B1: voltage bit val1=1 val0=0 rise=10p fall=10p period=1n data=101
  Stimulus B2: voltage bit val1=1 val0=0 rise=10p fall=10p period=1n data=100
  Stimulus B3: voltage bit val1=1 val0=0 rise=10p fall=10p period=1n data=100
  Stimulus C0: voltage bit val1=1 val0=0 rise=10p fall=10p period=1n data=101
  Analysis tran: stop=10n errpreset=conservative
  Signals: /S0, /S1, /S2, /S3, /C4
Run mode: Single Run, Sweeps and Corners

ADE simulation setup
Run mode: Single Run, Sweeps and Corners
Tests:
  demo_lab1_4_bit_rca_1: demo_lab1/4_bit_rca/schematic, simulator spectre
